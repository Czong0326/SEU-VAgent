//======================================================================
//Copyright @ 2014 Massachusetts Institute of Technology (MIT)
//
// The terms under which the software and associated documentation
// (the Software) is provided are as the following:
//
// The Software is provided "as is", without warranty of any kind,
// express or implied, including but not limited to the warranties of
// merchantability, fitness for a particular purpose and noninfringement.
// In no event shall the authors or copyright holders be liable for any claim,
// damages or other liability, whether in an action of contract,
// tort or otherwise, arising from, out of or in connection with the Software
// or the use or other dealings in the Software.
//
// MIT grants, free of charge, to any users the right to modify, copy,
// and redistribute the Software, both within the user's organization and
// externally, subject to the following restrictions:
//
// 1. The users agree not to charge for the MIT code itself but may charge
//      for additions, extensions, or support.
//
// 2. In any product based on the Software, the users agree to acknowledge
//      the MIT Computational Prototyping Research Group that developed
//      the software. This acknowledgment shall appear in the product
//      documentation.
//
// 3. The users agree to obey all U.S. Government restrictions governing
//      redistribution or export of the software.
//
// 4. The users agree to reproduce any copyright notice which appears on
//      the software on any copy or modification of such made available to others.
//
// Agreed to by
// Luca Daniel, MIT
// August 31st, 2014
//======================================================================
// rbt.va
//======================================================================
// RBT compact model (top level module)
//
// Version: 1.0.0
// Tested on: Cadence Spectre 13.1.1.049
//
// Author: Bichoy Bahr [bichoy at mit dot edu]
// Last Modified: Aug 31, 2014

`include "constants.vams"
`include "disciplines.vams"
`include "rbtConst.vams"

module rbt(p,n,d,g,s,b,T);

inout p,n;
inout d, g, s, b;
inout T;

electrical p,n;
electrical d, g, s, b;
thermal T;

//======================================================================
// Model parameters
//======================================================================

parameter real version = 1.00;				// Verion

// Dimensional parameters
parameter real rbt_L = `RBT_L from (0:inf); 		// Bar resonator length
parameter real rbt_W = `RBT_W from (0:inf);		// Width of the bar
parameter real rbt_THK = `RBT_THK from (0:inf);		// Thickness of the bar

parameter real rbt_g = `RBT_G from (0:inf);		// Drive dielectric thickness
parameter real rbt_d = `RBT_D from [0:inf);		// Drive position from START of bar

// Material properties
parameter real rbt_epsd = `RBT_EPSD from [1:inf);	// Drive dielectric permittivity
parameter real rbt_rho  = `RBT_RHO from (0:inf); 	// Density
parameter real rbt_Y    = `RBT_Y from (0:inf);	 	// Young's Modulus
parameter real rbt_nu   = `RBT_NU from [0:0.5];  	// Poisson's ratio
parameter real rbt_fQ   = `RBT_FQ from (0:inf);  	// Resonator Quality factor
parameter integer rbt_fQharm = `RBT_FQHARM from [1:inf);	// Harmonic for which fQ is calculated (assuming it is propotional to f)

// Termal properties
parameter real rbt_Tnom = `RBT_T0 from [0:inf); 	// Nominal temperature
parameter real rbt_Rth  = `RBT_RTH from (0:inf);	// Thermal resistance
parameter real rbt_cm   = `RBT_CM from (0:inf);		// Mass heat capacity
parameter real rbt_LTC  = `RBT_LTC from [0:inf);	// Expansion coefficient
parameter real rbt_LDTC  = `RBT_LDTC from [0:inf);	// Driving dielectric expansion coefficient
parameter real rbt_LSTC  = `RBT_LSTC from [0:inf);	// Sensing dielectric expansion coefficient
parameter real rbt_rhoTC= `RBT_RHOTC; 			// Density TC
parameter real rbt_YTC  = `RBT_YTC;			// Young's Modulus TC
parameter real rbt_nuTC = `RBT_NUTC; 			// Poisson's ratio TC
parameter real rbt_fQTC = `RBT_FQTC;			// fQ TC

// Sensing parameters
parameter integer rbt_HSense = `RBT_VSENSE from [`RBT_HSENSE:`RBT_VSENSE];
parameter real rbt_Lso = `RBT_LS0 from (0:inf);		// Position of the sensing FET channel
parameter real rbt_pitrans = `RBT_PITRANS;		// Transverse Piezoresistivity coefficient
parameter real rbt_pilong = `RBT_PILONG;		// Transverse Piezoresistivity coefficient

// Parasitics parameters
// Feed-through capacitances
parameter real rbt_Cfpd = `RBT_CFPD from [0:inf); // p to d series R
parameter real rbt_Cfpg = `RBT_CFPG from [0:inf); // p to g series R
parameter real rbt_Cfps = `RBT_CFPS from [0:inf); // p to s series R
parameter real rbt_Cfpb = `RBT_CFPB from [0:inf); // p to b series R
// Feed-through resistances
parameter real rbt_Rfpd = `RBT_RFPD from [0:inf); // p to d series C
parameter real rbt_Rfpg = `RBT_RFPG from [0:inf); // p to g series C
parameter real rbt_Rfps = `RBT_RFPS from [0:inf); // p to s series C
parameter real rbt_Rfpb = `RBT_RFPB from [0:inf); // p to b series C
// Body resistance
parameter real rbt_Rfnb = `RBT_RFNB from (0:inf); // n to b series R

// BSIM model parameters
parameter integer TYPE		= 1		from [`ptype:`ntype] exclude 0;
parameter integer CVMOD		= 0		from [0:1]; // 0: Consistent IV-CV
													// 1: Different IV-CV
parameter integer GEOMOD	= 0 		from [0:10];// Geo dependent parasitics model
parameter integer RGEOMOD	= 0		from [0:8]; // Geometry-dependent source/drain resistance
													//  0: RSH-based, 1: Holistic
parameter integer COVMOD	= 0		from [0:1]; // 0: Use Bias-independent Overlap Capacitances
													// 1: Use Bias-dependent Overlap Capacitances
parameter integer RDSMOD	= 0 		from [0:2]; // 0: Internal bias dependent and external bias independent s/d resistance model
													// 1: External s/d resistance model
													// 2: Internal s/d resistance model
parameter integer GIDLMOD	= 0		from [0:1]; // 0: Turn off GIDL Current
													// 1: Turn on GIDL Current
parameter integer RGATEMOD	= 0		from [0:3]; // Gate resistance model selector
parameter integer RBODYMOD	= 0		from [0:2]; // Distributed body R model
parameter integer IGCMOD	= 0		from [0:1]; // 0: Turn off Igc, Igs and Igd
													// 1: Turn on Igc, Igs and Igd
parameter integer IGBMOD	= 0		from [0:1]; // 0: Turn off Igb
													// 1: Turn on Igb
parameter integer TNOIMOD	= 0		from [0:1]; // Thermal noise model selector
parameter integer SHMOD		= 1		from [0:1]; // 1 : Self heating model ON
												// 1 : Self heating model ON
parameter real L	 	= `BSIM_LFET	from (0:inf);	// units are m
parameter real LLONG 		= `BSIM_LFET	from (0:inf);	// L of extracted Long channel device - units are m
parameter real LMLT		= 1.0	from (0:inf);	// Length Shrinking Parameter
parameter real WMLT		= 1.0	from (0:inf);	// Width Shrinking Parameter
parameter real XL 		= 0.0;			// L offset for channel length due to mask/etch effect
parameter real W	 	= `BSIM_WFET	from (0:inf);	// Total Width including fingers (units are m)
parameter real WWIDE 		= `BSIM_WFET	from (0:inf);	// W of extracted Wide channel device - units are m
parameter real XW 		= 0.0;					// W offset for channel width due to mask/etch effect
parameter real LINT		= 0.0;					// delta L for IV
parameter real LL		= 0.0;
parameter real LW		= 0.0;
parameter real LWL		= 0.0;
parameter real LLN		= 1.0;
parameter real LWN		= 1.0;
parameter real WINT		= 0.0;					// delta W for IV
parameter real WL		= 0.0;
parameter real WW		= 0.0;
parameter real WWL		= 0.0;
parameter real WLN		= 1.0;
parameter real WWN		= 1.0;
parameter real DLC		= 0.0;					// delta L for CV
parameter real LLC		= 0.0;
parameter real LWC		= 0.0;
parameter real LWLC		= 0.0;
parameter real DWC		= 0.0;					// delta W for CV
parameter real WLC		= 0.0;
parameter real WWC		= 0.0;
parameter real WWLC		= 0.0;
parameter real TOXE		= `BSIM_TOXFET;				// Effective gate dielectric thickness relative to SiO2, m
parameter real TOXP		= `BSIM_TOXFET;					// Physical gate dielectric thickness, m
												// If not given, TOXP is calculated from TOXE and DTOX
parameter real DTOX		= 0.0;					// Difference between effective dielectric thickness
												// and physical thickness
parameter integer NF	= 1		from [1:inf);	// number of fingers
parameter real NDEP 	= 1e24;					// Channel Doping Concentration (m^-3) for IV
parameter real NDEPL1 	= 0.0;					// Length dependence coefficient of NDEP
parameter real NDEPLEXP1 = 1.0	from (0:inf);			// Length dependence exponent coefficient of NDEP
parameter real NDEPL2 	= 0.0;					// Length dependence of NDEP - For Short Channel Devices
parameter real NDEPLEXP2 = 2.0	from (0:inf);			// Length dependence exponent coefficient of NDEP
parameter real NDEPW 	= 0.0;					// Width dependence coefficient of NDEP
parameter real NDEPWEXP = 1.0	from (0:inf);			// Width dependence exponent coefficient of NDEP
parameter real NDEPWL 	= 0.0;					// Width-Length dependence coefficient of NDEP
parameter real NDEPWLEXP = 1.0	from (0:inf);			// Width-Length dependence exponent coefficient of NDEP
parameter real LNDEP 	= 0.0;
parameter real WNDEP 	= 0.0;
parameter real PNDEP 	= 0.0;

parameter real NDEPCV 	= 1e24;					// Channel Doping Concentration (m^-3) for CV
parameter real NDEPCVL1 = 0.0;				// Length dependence coefficient of NDEPCV
parameter real NDEPCVLEXP1 = 1.0	from (0:inf);		// Length dependence exponent coefficient of NDEPCV
parameter real NDEPCVL2 = 0.0;				// Length dependence coefficient of NDEPCV - For Short Channel Devices
parameter real NDEPCVLEXP2 = 2.0	from (0:inf);		// Length dependence exponent coefficient of NDEPCV
parameter real NDEPCVW 	= 0.0;				// Width dependence coefficient of NDEPCV
parameter real NDEPCVWEXP = 1.0	from (0:inf);		// Width dependence exponent coefficient of NDEPCV
parameter real NDEPCVWL	= 0.0;				// Width-Length dependence coefficient of NDEPCV
parameter real NDEPCVWLEXP = 1.0	from (0:inf);	// Width-Length dependence exponent coefficient of NDEPCV
parameter real LNDEPCV 	= 0.0;
parameter real WNDEPCV 	= 0.0;
parameter real PNDEPCV 	= 0.0;

parameter real NGATE 	= `BSIM_NGATE;			// Gate Doping Concentration (m^-3)
parameter real LNGATE 	= 0.0;
parameter real WNGATE 	= 0.0;
parameter real PNGATE 	= 0.0;

parameter real EASUB 	= `BSIM_EASUB;			// Electron affinity of substrate, eV
parameter real NI0SUB 	= `BSIM_NI0SUB;			// Intrinsic carrier concentration of the substrate at 300.15K ( m^-3)
parameter real BG0SUB 	= `BSIM_BG0SUB; 		// Band gap of substrate at 300.15K, eV
parameter real EPSRSUB	= `BSIM_EPSRSUB;		// Relative dielectric constant of the channel material
parameter real EPSROX	= `BSIM_EPSROX;			// Relative dielectric constant of the gate dielectric
parameter real XJ 	= `BSIM_XJ;			// S/D junction depth
parameter real LXJ	= 0.0;
parameter real WXJ	= 0.0;
parameter real PXJ	= 0.0;
parameter real VFB	= `BSIM_VFB;			// Flat band voltage for IV
parameter real LVFB 	= 0.0;
parameter real WVFB 	= 0.0;
parameter real PVFB 	= 0.0;

parameter real VFBCV	= VFB;				// Flat band voltage for CV
parameter real LVFBCV 	= LVFB;
parameter real WVFBCV 	= WVFB;
parameter real PVFBCV 	= PVFB;
parameter real VFBCVL 	= 0.0;				// Length dependence coefficient of VFBCV
parameter real VFBCVLEXP = 1.0	from (0:inf);		// Length dependence exponent coefficient of VFBCV
parameter real VFBCVW 	= 0.0;				// Width dependence coefficient of VFBCV
parameter real VFBCVWEXP = 1.0	from (0:inf);		// Width dependence exponent coefficient of VFBCV
parameter real VFBCVWL 	= 0.0;				// Width-Length dependence coefficient of VFBCV
parameter real VFBCVWLEXP = 1.0	from (0:inf);		// Width-Length dependence coefficient of VFBCV

// BSIM Model Diode parameters
parameter integer PERMOD	= 1 from [0:1];		// Whether PS/PD (when given) include gate-edge perimeter
parameter real AS		= 0.0 from [0:inf);     // Source to Substrate Junction Area
parameter real AD		= 0.0 from [0:inf);     // Drain to Substrate Junction Area
parameter real PS		= 0.0 from [0:inf);     // Source to Substrate Junction Perimeter
parameter real PD		= 0.0 from [0:inf);     // Drain to Substrate Junction Perimeter
parameter real DWJ		= DWC;					// delta W for S/D junctions

// BSIM model Rd, Rs related Parameter
parameter real VFBSDOFF	= 0.0;
parameter real NRS		= 1.0 from [0:inf);	// Number of squares in source
parameter real NRD		= 1.0 from [0:inf);	// Number of squares in drain
parameter integer MINZ	= 0   from [0:1];		// Minimize either D or S

// BSIM model Short Channel Effects
parameter real NSD 	= `BSIM_NSD;			// S/D Doping Concentration (m^-3)
parameter real LNSD 	= 0.0;
parameter real WNSD 	= 0.0;
parameter real PNSD 	= 0.0;

parameter real DVTP0 	= 0.0;				// DITS
parameter real LDVTP0 	= 0;
parameter real WDVTP0 	= 0;
parameter real PDVTP0 	= 0;
parameter real DVTP1 	= 0.0;				// DITS
parameter real LDVTP1 	= 0;
parameter real WDVTP1 	= 0;
parameter real PDVTP1 	= 0;
parameter real DVTP2 	= 0.0;				// DITS
parameter real LDVTP2 	= 0;
parameter real WDVTP2 	= 0;
parameter real PDVTP2 	= 0;
parameter real DVTP3 	= 0.0;				// DITS
parameter real LDVTP3 	= 0;
parameter real WDVTP3 	= 0;
parameter real PDVTP3 	= 0;
parameter real DVTP4 	= 0.0;				// DITS
parameter real LDVTP4 	= 0;
parameter real WDVTP4 	= 0;
parameter real PDVTP4 	= 0;
parameter real DVTP5 	= 0.0;				// DITS
parameter real LDVTP5 	= 0;
parameter real WDVTP5 	= 0;
parameter real PDVTP5 	= 0;

parameter real PHIN 	= 0.045;			// Nonuniform vertical doping effect on surface potential, V
parameter real LPHIN 	= 0.0;
parameter real WPHIN 	= 0.0;
parameter real PPHIN 	= 0.0;

parameter real ETA0 	= 0.08;				// DIBL coefficient
parameter real LETA0	= 0.0;
parameter real WETA0 	= 0.0;
parameter real PETA0 	= 0.0;
parameter real DSUB 	= 1.0;				// Length scaling exponent for DIBL
parameter real ETAB 	= -0.07;			// Body bias coefficient for subthreshold DIBL effect
parameter real ETABEXP 	= 1.0	from (0:inf);		// Exponent coefficient of ETAB
parameter real LETAB 	= 0.0;
parameter real WETAB 	= 0.0;
parameter real PETAB 	= 0.0;

parameter real K2 	= 0.0;				// Vth shift due to Vertical Non-uniform doping
parameter real K2L 	= 0.0;				// Length dependence coefficient of K2
parameter real K2LEXP 	= 1.0	from (0:inf);		// Length dependence exponent coefficient of K2
parameter real K2W 	= 0.0;				// Width dependence coefficient of K2
parameter real K2WEXP 	= 1.0	from (0:inf);		// Width dependence exponent coefficient of K2
parameter real K2WL 	= 0.0;				// Width-Length dependence coefficient of K2
parameter real K2WLEXP 	= 1.0	from (0:inf);		// Width-Length dependence exponent coefficient of K2
parameter real LK2 	= 0.0;
parameter real WK2 	= 0.0;
parameter real PK2 	= 0.0;

// BSIM model Quantum Mechanical Effects
parameter real ADOS 	= 0.0 	from [0:inf);	// Quantum mechanical effect prefactor cum switch in inversion
parameter real BDOS 	= 1.0 	from [0:inf);	// Charge centroid parameter - slope of CV curve under QME in inversion
parameter real QM0 		= 1.0e-3 from (0:inf);	// Charge centroid parameter - starting point for QME in inversion
parameter real ETAQM	= 0.54	from [0:inf);	// Bulk charge coefficient for charge centroid in inversion

// BSIM model Subthreshold Swing Factor
parameter real CIT      = 0.0;			// parameter for interface trap
parameter real LCIT 	= 0.0;
parameter real WCIT 	= 0.0;
parameter real PCIT 	= 0.0;

parameter real NFACTOR 		= 0.0;				// Sub-threshold slope factor
parameter real NFACTORL 	= 0.0;			// Length dependence coefficient of NFACTOR
parameter real NFACTORLEXP 	= 1.0	from (0:inf);	// Length dependence exponent coefficient of NFACTOR
parameter real NFACTORW 	= 0.0;			// Width dependence coefficient of NFACTOR
parameter real NFACTORWEXP 	= 1.0	from (0:inf);	// Width dependence exponent coefficient of NFACTOR
parameter real NFACTORWL 	= 0.0;			// Width-Length dependence coefficient of NFACTOR
parameter real NFACTORWLEXP 	= 1.0	from (0:inf);	// Width-Length dependence exponent coefficient of NFACTOR
parameter real LNFACTOR 	= 0.0;
parameter real WNFACTOR 	= 0.0;
parameter real PNFACTOR 	= 0.0;

parameter real CDSCD 	= 1e-9;				// drain-bias sensitivity of sub-threshold slope
parameter real CDSCDL 	= 0.0;				// Length dependence coefficient of CDSCD
parameter real CDSCDLEXP = 1.0	from (0:inf);		// Length dependence exponent coefficient of CDSCD
parameter real LCDSCD 	= 0.0;
parameter real WCDSCD 	= 0.0;
parameter real PCDSCD 	= 0.0;
parameter real CDSCB 	= 0.0;				// body-bias sensitivity of sub-threshold slope
parameter real CDSCBL 	= 0.0;				// Length dependence coefficient of CDSCB
parameter real CDSCBLEXP = 1.0	from (0:inf);		// Length dependence exponent coefficient of CDSCB
parameter real LCDSCB 	= 0.0;
parameter real WCDSCB 	= 0.0;
parameter real PCDSCB 	= 0.0;

// BSIM model Drain Saturation Voltage
parameter real VSAT		= 1e5;					// Saturation Velocity m/s
parameter real LVSAT		= 0.0;
parameter real WVSAT		= 0.0;
parameter real PVSAT		= 0.0;
parameter real VSATL		= 0.0;					// Length dependence coefficient of of VSAT
parameter real VSATLEXP		= 1.0	from (0:inf);			// Length dependence exponent coefficient of VSAT
parameter real VSATW		= 0.0;					// Width dependence coefficient of of VSAT
parameter real VSATWEXP		= 1.0	from (0:inf);			// Width dependence exponent coefficient of of VSAT
parameter real VSATWL		= 0.0;					// Width-Length dependence coefficient of of VSAT
parameter real VSATWLEXP	= 1.0	from (0:inf);			// Width-Length dependence exponent coefficient of of VSAT
parameter real DELTA		= 0.125;				// Smoothing function factor for Vdsat
parameter real LDELTA		= 0.0;
parameter real WDELTA		= 0.0;
parameter real PDELTA		= 0.0;
parameter real DELTAL		= 0.0;					// Length dependence coefficient of DELTA
parameter real DELTALEXP 	= 1.0	from (0:inf);			// Length dependence exponent coefficient of DELTA

parameter real VSATCV		= VSAT;					// VSAT parameter for CV
parameter real LVSATCV		= LVSAT;
parameter real WVSATCV		= WVSAT;
parameter real PVSATCV		= PVSAT;
parameter real VSATCVL		= VSATL;
parameter real VSATCVLEXP 	= VSATLEXP	from (0:inf);
parameter real VSATCVW		= VSATW;
parameter real VSATCVWEXP 	= VSATWEXP	from (0:inf);
parameter real VSATCVWL		= VSATWL;
parameter real VSATCVWLEXP 	= VSATWLEXP	from (0:inf);

// BSIM model Mobility Degradation
parameter real U0		= 67.0e-3;			// units are m2/Vs
parameter real U0L		= 0.0;				// Length dependence coefficient of U0L
parameter real U0LEXP		= 1.0	from (0:inf);		// Length dependence exponent coefficient of U0L
parameter real LU0		= 0.0;
parameter real WU0		= 0.0;
parameter real PU0		= 0.0;

parameter real ETAMOB		= 1.0;				// Effective field parameter (should be kept close to 1)

parameter real UA		= 0.001;			// Mobility reduction coefficient
parameter real UAL		= 0.0;				// Length dependence coefficient of  UA
parameter real UALEXP		= 1.0	from (0:inf);		// Length dependence exponent coefficient of  UA
parameter real UAW		= 0.0;				// Width dependence coefficient of UA
parameter real UAWEXP		= 1.0	from (0:inf);		// Width dependence exponent coefficient of UA
parameter real UAWL		= 0.0;				// Width-Length dependence coefficient of UA
parameter real UAWLEXP		= 1.0	from (0:inf);		// Width-Length dependence coefficient of UA
parameter real LUA		= 0.0;
parameter real WUA		= 0.0;
parameter real PUA		= 0.0;

parameter real EU		= 1.5;				// Mobility reduction exponent
parameter real LEU		= 0.0;
parameter real WEU		= 0.0;
parameter real PEU		= 0.0;
parameter real EUL		= 0.0;					// Length dependence coefficient of EU
parameter real EULEXP		= 1.0	from (0:inf);			// Length dependence exponent coefficient of EU
parameter real EUW		= 0.0;					// Width dependence coefficient of EU
parameter real EUWEXP		= 1.0	from (0:inf);			// Width dependence exponent coefficient of EU
parameter real EUWL		= 0.0;					// Width-Length dependence coefficient of EU
parameter real EUWLEXP		= 1.0	from (0:inf);			// Width-Length dependence coefficient of EU

parameter real UD		= 0.001;				// Coulombic scattering parameter
parameter real UDL		= 0.0;					// Length dependence coefficient of UD
parameter real UDLEXP		= 1.0	from (0:inf);			// Length dependence exponent coefficient of UD
parameter real LUD		= 0.0;
parameter real WUD		= 0.0;
parameter real PUD		= 0.0;

parameter real UCS		= 2.0;					// Coulombic scattering parameter
parameter real LUCS		= 0.0;
parameter real WUCS		= 0.0;
parameter real PUCS		= 0.0;

parameter real UC		= 0.0;					// Mobility reduction with body bias
parameter real UCL		= 0.0;					// Length dependence coefficient of UC
parameter real UCLEXP		= 1.0	from (0:inf);			// Length dependence exponent coefficient of UC
parameter real UCW		= 0.0;					// Width dependence coefficient of UC
parameter real UCWEXP		= 1.0	from (0:inf);			// Width dependence exponent coefficient of UC
parameter real UCWL		= 0.0;					// Width-Length dependence coefficient of UC
parameter real UCWLEXP		= 1.0	from (0:inf);			// Width-Length dependence exponent coefficient of UC
parameter real LUC		= 0.0;
parameter real WUC		= 0.0;
parameter real PUC		= 0.0;

// BSIM model Channel Length Modulation
parameter real PCLM		    = 0.0;				// CLM prefactor
parameter real PCLML		= 0.0;				// Length dependence coefficient of PCLM
parameter real PCLMLEXP 	= 1.0 from (0:inf);		// Length dependence exponent coefficient of PCLM
parameter real LPCLM		= 0.0;
parameter real WPCLM		= 0.0;
parameter real PPCLM		= 0.0;

parameter real PCLMG		= 0.0;				// CLM prefactor gate voltage dependence

parameter real PCLMCV		= PCLM;				// CLM parameter for CV
parameter real PCLMCVL		= PCLML;
parameter real PCLMCVLEXP	= PCLMLEXP from (0:inf);
parameter real LPCLMCV		= LPCLM;
parameter real WPCLMCV		= WPCLM;
parameter real PPCLMCV		= PPCLM;

parameter real PSCBE1 	= 4.24e8;				// Substrate current body-effect coeff
parameter real LPSCBE1 	= 0.0;
parameter real WPSCBE1 	= 0.0;
parameter real PPSCBE1 	= 0.0;
parameter real PSCBE2 	= 1.0e-8;				// Substrate current body-effect coeff
parameter real LPSCBE2 	= 0.0;
parameter real WPSCBE2 	= 0.0;
parameter real PPSCBE2 	= 0.0;

parameter real PDITS 	= 0.0;   			// Coefficient for drain-induced Vth shifts
parameter real LPDITS 	= 0.0;
parameter real WPDITS 	= 0.0;
parameter real PPDITS 	= 0.0;
parameter real PDITSL 	= 0.0 from [0:inf);		// L dep of drain-induced Vth shifts
parameter real PDITSD 	= 0.0;					// Vds dep of drain-induced Vth shifts
parameter real LPDITSD 	= 0.0;
parameter real WPDITSD 	= 0.0;
parameter real PPDITSD 	= 0.0;

// BSIM model S/D Series Resistance
parameter real RSH 	= 0.0 from [0:inf);		// Source-drain sheet resistance [Ohm]
parameter real PRWG 	= 1.0;					// gate bias dependence of S/D extension resistance, V-1
parameter real LPRWG 	= 0.0;
parameter real WPRWG 	= 0.0;
parameter real PPRWG 	= 0.0;
parameter real PRWB 	= 0.0;					// Body bias dependence of resistance
parameter real LPRWB 	= 0.0;
parameter real WPRWB 	= 0.0;
parameter real PPRWB 	= 0.0;
parameter real PRWBL 	= 0.0;					// Length dependence coefficient of PPRWB
parameter real PRWBLEXP	= 1.0	from (0:inf);			// Length dependence exponent coefficient of PPRWB
parameter real WR 	= 1.0;					// W dependence parameter of S/D extension resistance
parameter real LWR 	= 0.0;
parameter real WWR 	= 0.0;
parameter real PWR 	= 0.0;

parameter real RSWMIN 	= 0.0;					// Source Resistance per unit width at high Vgs (RDSMOD=1)
parameter real LRSWMIN 	= 0.0;
parameter real WRSWMIN 	= 0.0;
parameter real PRSWMIN 	= 0.0;
parameter real RSW 	= 10.0;					// zero bias Source Resistance (RDSMOD=1)
parameter real LRSW 	= 0.0;
parameter real WRSW 	= 0.0;
parameter real PRSW 	= 0.0;
parameter real RSWL 	= 0.0;					// Geometrical scaling of RSW (RDSMOD=1)
parameter real RSWLEXP 	= 1.0	from (0:inf);			// Geometrical scaling of RSW (RDSMOD=1)

parameter real RDWMIN 	= RSWMIN;				// Drain Resistance per unit width at high Vgs (RDSMOD=1)
parameter real LRDWMIN 	= LRSWMIN;
parameter real WRDWMIN 	= WRSWMIN;
parameter real PRDWMIN 	= PRSWMIN;
parameter real RDW 	= RSW;					// zero bias Drain Resistance (RDSMOD=1)
parameter real LRDW 	= LRSW;
parameter real WRDW 	= WRSW;
parameter real PRDW 	= PRSW;
parameter real RDWL 	= RSWL;					// Geometrical scaling of RDW (RDSMOD=1)
parameter real RDWLEXP 	= RSWLEXP	from (0:inf);		// Geometrical scaling of RDW (RDSMOD=1)

parameter real RDSWMIN 	= 0.0;					// S/D Resistance per unit width at high Vgs (RDSMOD=0 and RDSMOD=2)
parameter real LRDSWMIN = 0.0;
parameter real WRDSWMIN = 0.0;
parameter real PRDSWMIN = 0.0;
parameter real RDSW 	= 20.0;					// zero bias Resistance (RDSMOD=0 and RDSMOD=2)
parameter real RDSWL 	= 0.0;					// Geometrical scaling of RDSW (RDSMOD=0 and RDSMOD=2)
parameter real RDSWLEXP = 1.0	from (0:inf); 			// Geometrical scaling of RDSW (RDSMOD=0 and RDSMOD=2)
parameter real LRDSW 	= 0.0;
parameter real WRDSW 	= 0.0;
parameter real PRDSW 	= 0.0;

// BSIM model Velocity Saturation

parameter real PSAT 	= 1.0;				// Gmsat variation with gate bias
parameter real LPSAT 	= 0.0;
parameter real WPSAT 	= 0.0;
parameter real PPSAT 	= 0.0;
parameter real PSATL 	= 0.0;
parameter real PSATLEXP = 1.0	from (0:inf);
parameter real PSATB	= 0.0;					// Body bias effect on Idsat
parameter real LPSATB	= 0.0;
parameter real WPSATB	= 0.0;
parameter real PPSATB	= 0.0;

parameter real PSATX	= 1.0 from (0:inf);
parameter real PTWG 	= 0.0;					// Idsat variation with gate bias
parameter real LPTWG 	= 0.0;
parameter real WPTWG 	= 0.0;
parameter real PPTWG 	= 0.0;
parameter real PTWGL 	= 0.0;					// Length dependence coefficient of PTWG
parameter real PTWGLEXP = 1.0	from (0:inf);			// Length dependence exponent coefficient of PTWG

// BSIM model Output Conductance
parameter real PDIBLC 	= 0.0;					// parameter for DIBL effect on Rout
parameter real PDIBLCL  = 0.0;					// Length dependence coefficient of PDIBLC
parameter real PDIBLCLEXP = 1.0	from (0:inf);			// Length dependence exponent coefficient of PDIBLC
parameter real LPDIBLC  = 0.0;
parameter real WPDIBLC  = 0.0;
parameter real PPDIBLC  = 0.0;

parameter real PDIBLCB 	= 0.0;					// parameter for DIBL effect on Rout
parameter real LPDIBLCB = 0.0;
parameter real WPDIBLCB = 0.0;
parameter real PPDIBLCB = 0.0;

parameter real PVAG 	= 1.0;					// Vg dependence of early voltage
parameter real LPVAG 	= 0.0;
parameter real WPVAG 	= 0.0;
parameter real PPVAG 	= 0.0;

parameter real FPROUT 	= 0.0;
parameter real FPROUTL 	= 0.0; 					// Length dependence coefficient of FPROUT
parameter real FPROUTLEXP = 1.0	from (0:inf);			// Length dependence exponent coefficient of FPROUT
parameter real LFPROUT 	= 0.0;
parameter real WFPROUT 	= 0.0;
parameter real PFPROUT 	= 0.0;

// BSIM model Impact Ionization Current
parameter real ALPHA0	= 0.0;					// first parameter of Iii, m/V
parameter real ALPHA0L	= 0.0;					// Length dependence coefficient of ALPHA0
parameter real ALPHA0LEXP = 1.0	from (0:inf);			// Length dependence exponent coefficient of ALPHA0
parameter real LALPHA0	= 0.0;
parameter real WALPHA0	= 0.0;
parameter real PALPHA0	= 0.0;

parameter real BETA0	= 0.0;					// Vds dependent parameter of Iii, 1/V
parameter real LBETA0	= 0.0;
parameter real WBETA0	= 0.0;
parameter real PBETA0	= 0.0;

// BSIM model Gate Dielectric Tunneling Current Model Parameters
parameter real AIGBACC = 1.36e-2;	 			// Parameter for Igb
parameter real BIGBACC = 1.71e-3;	 			// Parameter for Igb
parameter real CIGBACC = 0.075;	 				// Parameter for Igb
parameter real NIGBACC = 1.0;	 				// Parameter for Igbacc slope
parameter real AIGBINV = 1.11e-2;	 			// Parameter for Igb
parameter real BIGBINV = 9.49e-4;	 			// Parameter for Igb
parameter real CIGBINV = 0.006;	 				// Parameter for Igb
parameter real EIGBINV = 1.1;	 				// Parm for the Si bandgap for Igbinv [V]
parameter real NIGBINV = 3.0;	 				// Parameter for Igbinv slope
parameter real AIGC = (TYPE == `ntype) ? 1.36e-2 : 9.8e-3; 		// Parameter for Igc
parameter real BIGC = (TYPE == `ntype) ? 1.71e-3 : 7.59e-4; 		// Parameter for Igc
parameter real CIGC = (TYPE == `ntype) ? 0.075 : 0.03; 			// Parameter for Igc
parameter real AIGS = (TYPE == `ntype) ? 1.36e-2 : 9.8e-3; 		// Parameter for Igs d
parameter real BIGS = (TYPE == `ntype) ? 1.71e-3 : 7.59e-4; 		// Parameter for Igs d
parameter real CIGS = (TYPE == `ntype) ? 0.075 : 0.03; 			// Parameter for Igs d
parameter real AIGD = (TYPE == `ntype) ? 1.36e-2 : 9.8e-3; 		// Parameter for Igs d
parameter real BIGD = (TYPE == `ntype) ? 1.71e-3 : 7.59e-4; 		// Parameter for Igs d
parameter real CIGD = (TYPE == `ntype) ? 0.075 : 0.03; 			// Parameter for Igs d
parameter real DLCIG  = LINT;					// Delta L for Ig model [m]
parameter real DLCIGD = DLCIG;					// Delta L for Ig model [m]
parameter real POXEDGE = 1.0;					// Factor for the gate edge Tox
parameter real NTOX = 1.0;						// Exponent for Tox ratio
parameter real TOXREF = 3.0e-9 from (0:inf);			// Target tox value [m]
parameter real PIGCD = 1.0 from [-50:50];			// Igc, S/D partition parameter

parameter real AIGCL = 0.0; 					// Length dependence coefficient of AIGC
parameter real AIGCW = 0.0; 					// Width dependence coefficient of AIGC
parameter real AIGSL = 0.0; 					// Length dependence coefficient of AIGS
parameter real AIGSW = 0.0; 					// Width dependence coefficient of AIGS
parameter real AIGDL = 0.0; 					// Length dependence coefficient of AIGD
parameter real AIGDW = 0.0; 					// Width dependence coefficient of AIGD
parameter real PIGCDL = 0.0; 					// Length dependence coefficient of PIGCD

parameter real LAIGBINV = 0.0;
parameter real WAIGBINV = 0.0;
parameter real PAIGBINV = 0.0;

parameter real LBIGBINV = 0.0;
parameter real WBIGBINV = 0.0;
parameter real PBIGBINV = 0.0;

parameter real LCIGBINV = 0.0;
parameter real WCIGBINV = 0.0;
parameter real PCIGBINV = 0.0;

parameter real LEIGBINV = 0.0;
parameter real WEIGBINV = 0.0;
parameter real PEIGBINV = 0.0;

parameter real LNIGBINV = 0.0;
parameter real WNIGBINV = 0.0;
parameter real PNIGBINV = 0.0;

parameter real LAIGBACC = 0.0;
parameter real WAIGBACC = 0.0;
parameter real PAIGBACC = 0.0;

parameter real LBIGBACC = 0.0;
parameter real WBIGBACC = 0.0;
parameter real PBIGBACC = 0.0;

parameter real LCIGBACC = 0.0;
parameter real WCIGBACC = 0.0;
parameter real PCIGBACC = 0.0;

parameter real LNIGBACC = 0.0;
parameter real WNIGBACC = 0.0;
parameter real PNIGBACC = 0.0;

parameter real LAIGC = 0.0;
parameter real WAIGC = 0.0;
parameter real PAIGC = 0.0;

parameter real LBIGC = 0.0;
parameter real WBIGC = 0.0;
parameter real PBIGC = 0.0;

parameter real LCIGC = 0.0;
parameter real WCIGC = 0.0;
parameter real PCIGC = 0.0;

parameter real LAIGS = 0.0;
parameter real WAIGS = 0.0;
parameter real PAIGS = 0.0;

parameter real LBIGS = 0.0;
parameter real WBIGS = 0.0;
parameter real PBIGS = 0.0;

parameter real LCIGS = 0.0;
parameter real WCIGS = 0.0;
parameter real PCIGS = 0.0;

parameter real LAIGD = 0.0;
parameter real WAIGD = 0.0;
parameter real PAIGD = 0.0;

parameter real LBIGD = 0.0;
parameter real WBIGD = 0.0;
parameter real PBIGD = 0.0;

parameter real LCIGD = 0.0;
parameter real WCIGD = 0.0;
parameter real PCIGD = 0.0;

parameter real LPOXEDGE = 0.0;
parameter real WPOXEDGE = 0.0;
parameter real PPOXEDGE = 0.0;

parameter real LDLCIG = 0.0;
parameter real WDLCIG = 0.0;
parameter real PDLCIG = 0.0;

parameter real LDLCIGD = 0.0;
parameter real WDLCIGD = 0.0;
parameter real PDLCIGD = 0.0;

parameter real LNTOX = 0.0;
parameter real WNTOX = 0.0;
parameter real PNTOX = 0.0;

// BSIM model GIDL/GISL Current
parameter real AGIDL	= 0.0;					// pre-exponential coeff. for GIDL in mho
parameter real AGIDLL	= 0.0;					// Length dependence coefficient of AGIDL
parameter real AGIDLW	= 0.0;					// Width dependence coefficient of AGIDL
parameter real LAGIDL	= 0.0;
parameter real WAGIDL	= 0.0;
parameter real PAGIDL	= 0.0;
parameter real BGIDL	= 2.3e9;				// exponential coeff. for GIDL in V/m
parameter real LBGIDL	= 0.0;
parameter real WBGIDL	= 0.0;
parameter real PBGIDL	= 0.0;

parameter real CGIDL	= 0.5;       				// exponential coeff. for GIDL in V/m
parameter real LCGIDL	= 0.0;
parameter real WCGIDL	= 0.0;
parameter real PCGIDL	= 0.0;
parameter real EGIDL	= 0.8;					// band bending parameter for GIDL in V
parameter real LEGIDL	= 0.0;
parameter real WEGIDL	= 0.0;
parameter real PEGIDL	= 0.0;
parameter real AGISL	= AGIDL;				// pre-exponential coeff. for GISL in mho
parameter real AGISLL	= AGIDLL;				// Length dependence coefficient of AGISL
parameter real AGISLW	= AGIDLW;				// Width dependence coefficient of AGISL
parameter real LAGISL	= LAGIDL;
parameter real WAGISL	= WAGIDL;
parameter real PAGISL	= PAGIDL;
parameter real BGISL	= BGIDL;				// exponential coeff. for GISL in V/m
parameter real LBGISL	= LBGIDL;
parameter real WBGISL	= WBGIDL;
parameter real PBGISL	= PBGIDL;
parameter real CGISL	= CGIDL;                		// exponential coeff. for GISL in V/m
parameter real LCGISL	= LCGIDL;
parameter real WCGISL	= WCGIDL;
parameter real PCGISL	= PCGIDL;
parameter real EGISL	= EGIDL;				// band bending parameter for GISL in V
parameter real LEGISL	= LEGIDL;
parameter real WEGISL	= WEGIDL;
parameter real PEGISL	= PEGIDL;

// BSIM model Overlap Cap and Fringing Cap
parameter real CF 		= 0.0;					// Outer Fringe Cap (F)
parameter real LCF 		= 0.0;
parameter real WCF 		= 0.0;
parameter real PCF 		= 0.0;
parameter real CFRCOEFF = 1.0 from [1.0:inf);	// Coefficient for Outer Fringe Cap (F)
parameter real CGSO		= 0.0;					// Gate - Source overlap capacitance (F)
parameter real CGDO		= 0.0;					// Gate - Drain overlap capacitance (F)
parameter real CGBO		= 0.0;					// Gate - Body overlap capacitance (F)
parameter real CGSL		= 0.0;
parameter real LCGSL	= 0.0;
parameter real WCGSL	= 0.0;
parameter real PCGSL	= 0.0;
parameter real CGDL		= 0.0;
parameter real LCGDL	= 0.0;
parameter real WCGDL	= 0.0;
parameter real PCGDL	= 0.0;
parameter real CKAPPAS	= 0.6;
parameter real LCKAPPAS	= 0.0;
parameter real WCKAPPAS	= 0.0;
parameter real PCKAPPAS	= 0.0;
parameter real CKAPPAD	= 0.6;
parameter real LCKAPPAD	= 0.0;
parameter real WCKAPPAD	= 0.0;
parameter real PCKAPPAD	= 0.0;

// BSIM model Layout-Dependent Parasitics Model Parameters ....Resistance only
parameter real DMCG 	= 0.0;					// Distance of Mid-Contact to Gate edge [m]
parameter real DMCI 	= DMCG;					// Distance of Mid-Contact to Isolation [m]
parameter real DMDG 	= 0.0;					// Distance of Mid-Diffusion to Gate edge [m]
parameter real DMCGT 	= 0.0;					// Dist of Mid-Contact to Gate edge in Test [m]

`ifdef __RGATEMOD__
	parameter real XGW		= 0.0;					// Dist from gate contact center to dev edge [m]
	parameter real XGL		= 0.0 from (-inf:L*LMLT+XL);	// Variation in Ldrawn [m]
	parameter integer NGCON = 1 from [1:2];			// Number of gate contacts
	parameter real RSHG		= 0.1 from [0:inf);		// Gate sheet resistance [Ohm]
`endif

// BSIM model Junction current and capacitance
// BSIM model Junction Capacitance
parameter real CJS 		= 5.0e-4;				// Unit area source-side junction capacitance at zero bias
parameter real CJD 		= CJS;					// Unit area drain-side junction capacitance at zero bias
parameter real CJSWS 	= 5.0e-10;				// Unit length source-side sidewall junction capacitance at zero bias
parameter real CJSWD 	= CJSWS;				// Unit length drain-side sidewall junction capacitance at zero bias
parameter real CJSWGS 	= 0.0;					// Unit length source-side gate sidewall junction capacitance at zero bias
parameter real CJSWGD 	= CJSWGS;				// Unit length drain-side gate sidewall junction capacitance at zero bias
parameter real PBS 		= 1.0;					// Source-side bulk junction built-in potential
parameter real PBD 		= PBS;					// Drain-side bulk junction built-in potential
parameter real PBSWS 	= 1.0;					// Built-in potential for Source-side sidewall junction capacitance
parameter real PBSWD 	= PBSWS;				// Built-in potential for Drain-side sidewall junction capacitance
parameter real PBSWGS 	= PBSWS;				// Built-in potential for Source-side gate sidewall junction capacitance
parameter real PBSWGD 	= PBSWGS;				// Built-in potential for Drain-side gate sidewall junction capacitance
parameter real MJS 		= 0.5;					// Source bottom junction capacitance grading coefficient
parameter real MJD 		= MJS;					// Drain bottom junction capacitance grading coefficient
parameter real MJSWS 	= 0.33;					// Source sidewall junction capacitance grading coefficient
parameter real MJSWD 	= MJSWS;				// Drain sidewall junction capacitance grading coefficient
parameter real MJSWGS 	= MJSWS;				// Source-side gate sidewall junction capacitance grading coefficient
parameter real MJSWGD 	= MJSWGS;				// Drain-side gate sidewall junction capacitance grading coefficient

// BSIM model Junction Current
parameter real JSS 		= 1.0e-4;				// Bottom source junction reverse saturation current density
parameter real JSD 		= JSS;					// Bottom drain junction reverse saturation current density
parameter real JSWS 	= 0.0;					// Unit length reverse saturation current for sidewall source junction
parameter real JSWD 	= JSWS;					// Unit length reverse saturation current for sidewall drain junction
parameter real JSWGS 	= 0.0;					// Unit length reverse saturation current for gate-edge sidewall source junction
parameter real JSWGD 	= JSWGS;				// Unit length reverse saturation current for gate-edge sidewall drain junction
parameter real NJS 		= 1.0;					// Source junction emission coefficient
parameter real NJD 		= NJS;					// Drain junction emission coefficient
parameter real IJTHSFWD = 0.1;					// Forward source diode breakdown limiting current
parameter real IJTHDFWD = IJTHSFWD;				// Forward drain diode breakdown limiting current
parameter real IJTHSREV = 0.1;					// Reverse source diode breakdown limiting current
parameter real IJTHDREV = IJTHSREV;				// Reverse drain diode breakdown limiting current
parameter real BVS 		= 10.0;					// Source diode breakdown voltage
parameter real BVD 		= BVS;					// Drain diode breakdown voltage
parameter real XJBVS 	= 1.0;					// Fitting parameter for source diode breakdown current
parameter real XJBVD 	= XJBVS;				// Fitting parameter for drain diode breakdown current

// BSIM model Tunneling Component of Junction Current
parameter real JTSS 	= 0.0;					// Bottom source junction trap-assisted saturation current density
parameter real JTSD 	= JTSS;					// Bottom drain junction trap-assisted saturation current density
parameter real JTSSWS 	= 0.0;					// Unit length trap-assisted saturation current for sidewall source junction
parameter real JTSSWD 	= JTSSWS;				// Unit length trap-assisted saturation current for sidewall drain junction
parameter real JTSSWGS 	= 0.0;					// Unit length trap-assisted saturation current for gate-edge sidewall source junction
parameter real JTSSWGD 	= JTSSWGS;				// Unit length trap-assisted saturation current for gate-edge sidewall drain junction
parameter real JTWEFF 	= 0.0;					// Trap assisted tunneling current width dependence
parameter real NJTS 	= 20.0;					// Non-ideality factor for JTSS
parameter real NJTSD 	= NJTS;					// Non-ideality factor for JTSD
parameter real NJTSSW 	= 20.0;					// Non-ideality factor for JTSSWS
parameter real NJTSSWD 	= NJTSSW;				// Non-ideality factor for JTSSWD
parameter real NJTSSWG 	= 20.0;					// Non-ideality factor for JTSSWGS
parameter real NJTSSWGD = NJTSSWG;				// Non-ideality factor for JTSSWGD
parameter real VTSS 	= 10.0;					// Bottom source junction trap-assisted current voltage dependent parameter
parameter real VTSD 	= VTSS;					// Bottom drain junction trap-assisted current voltage dependent parameter
parameter real VTSSWS 	= 10.0;					// Unit length trap-assisted current voltage dependent parameter
												// for sidewall source junction
parameter real VTSSWD 	= VTSSWS;				// Unit length trap-assisted current voltage dependent parameter
												// for sidewall drain junction
parameter real VTSSWGS 	= 10.0;					// Unit length trap-assisted current voltage dependent parameter for
												// gate-edge sidewall source junction
parameter real VTSSWGD 	= VTSSWGS;				// Unit length trap-assisted current voltage dependent parameter for
												// gate-edge sidewall drain junction

// BSIM model High-Speed/RF Model Parameters
`ifdef __RGATEMOD__
	parameter real XRCRG1	= 12.0;			    // 1st fitting parm the bias-dependent Rg //make it binnable
	parameter real XRCRG2	= 1.0;			    // 2nd fitting parm the bias-dependent Rg  //make it binnable
`endif
`ifdef __RBODYMOD__
	parameter real RBPB		= 50.0 from [0:inf);	// Resistance between bNodePrime and bNode [Ohm]
	parameter real RBDB		= 50.0 from [0:inf);	// Resistance between bNode and dbNode [Ohm]
	parameter real RBSB		= 50.0 from [0:inf);	// Resistance between bNode and sbNode [Ohm]
	parameter real RBPS		= 50.0 from [0:inf);	// Resistance between bNodePrime and sbNode [Ohm]
	parameter real RBPD		= 50.0 from [0:inf);	// Resistance between bNodePrime and bNode [Ohm]
	parameter real GBMIN	= 1.0e-12 from [0:inf);	// Minimum body conductance
	parameter real RBPS0	= 50.0 from (0:inf);	// Scaling prefactor for RBPS 50 Ohms
	parameter real RBPSL	= 0.0 from [0:inf);		//Length Scaling parameter for RBPS
	parameter real RBPSW	= 0.0 from [0:inf);		//Width Scaling parameter for RBPS
	parameter real RBPSNF	= 0.0 from [0:inf);		//Number of fingers Scaling parameter for RBPS
	parameter real RBPD0	= 50.0 from (0:inf);	//Scaling prefactor for RBPD
	parameter real RBPDL	= 0.0 from [0:inf);		// Length Scaling parameter for RBPD
	parameter real RBPDW	= 0.0 from [0:inf);		// Width Scaling parameter for RBPD
	parameter real RBPDNF	= 0.0 from [0:inf);		// Number of fingers Scaling parameter for RBPD
	parameter real RBPBX0	= 100.0 from (0:inf);	//Scaling prefactor for RBPBX
	parameter real RBPBXL	= 0.0 from [0:inf);		// Length Scaling parameter for RBPBX
	parameter real RBPBXW	= 0.0 from [0:inf);		// Width Scaling parameter for RBPBX
	parameter real RBPBXNF	= 0.0 from [0:inf);		// Number of fingers Scaling parameter for RBPBX
	parameter real RBPBY0	= 100.0 from (0:inf);	// Scaling prefactor for RBPBY
	parameter real RBPBYL	= 0.0 from [0:inf);		// Length Scaling parameter for RBPBY
	parameter real RBPBYW	= 0.0 from [0:inf);		// Width Scaling parameter for RBPBY
	parameter real RBPBYNF	= 0.0 from [0:inf);		// Number of fingers Scaling parameter for RBPBY
	parameter real RBSBX0	= 100.0 from (0:inf);	// Scaling prefactor for RBSBX
	parameter real RBSBY0	= 100.0 from (0:inf);	// Scaling prefactor for RBSBY
	parameter real RBDBX0	= 100.0 from (0:inf);	// Scaling prefactor for RBDBX
	parameter real RBDBY0	= 100.0 from (0:inf);	// Scaling prefactor for RBDBY
	parameter real RBSDBXL	= 0.0 from [0:inf);		// Length Scaling parameter for RBSBX and RBDBX
	parameter real RBSDBXW	= 0.0 from [0:inf);		// Width Scaling parameter for RBSBX and RBDBX
	parameter real RBSDBXNF	= 0.0 from [0:inf);		// Number of fingers Scaling parameter for RBSBX and RBDBX
	parameter real RBSDBYL	= 0.0 from [0:inf);		// Length Scaling parameter for RBSBY and RBDBY
	parameter real RBSDBYW	= 0.0 from [0:inf);		// Width Scaling parameter for RBSBY and RBDBY
	parameter real RBSDBYNF	= 0.0 from [0:inf);		// Number of fingers Scaling parameter for RBSBY and RBDBY
`endif

// BSIM model Flicker Noise
parameter real EF		= 1.0 from (0:2];		// Flicker Noise frequency exponent
parameter real EM		= 4.1e7;
parameter real NOIA		= 6.250e+40;
parameter real NOIB		= 3.125e+25;
parameter real NOIC		= 8.750e+8;
parameter real LINTNOI	= 0.0;

// BSIM model Thermal Noise
parameter real NTNOI = 1.0	from [0:inf);
`ifdef __TNOISW__
	parameter real RNOIA = 0.577;				// TNOIMOD = 1
	parameter real RNOIB = 0.5164;				// TNOIMOD = 1
	parameter real RNOIC = 0.395;				// TNOIMOD = 1
	parameter real TNOIA = 0.0 from [0:inf);		// TNOIMOD = 1
	parameter real TNOIB = 0.0 from [0:inf);		// TNOIMOD = 1
	parameter real TNOIC = 0.0 from [0:inf);		// Correlation coefficient
`endif

// BSIM model Binning Parameters
parameter integer BINUNIT	= 1		from [0:1]; //	Unit of L and W for Binning
							    //  1 : micro-meter, 0 : default
parameter real DLBIN = 0.0;
parameter real DWBIN = 0.0;

// BSIM model Temperature Dependence Parameters
parameter real TNOM 	= 27.0;					// Temperature at which the model was extracted (degrees)
parameter real DTEMP 	= 0.0;					// Offset of Device Temperature

parameter real TBGASUB 	= 4.73e-4;				// Bandgap Temperature Coefficient (eV / degrees)
parameter real TBGBSUB 	= 636.0;				// Bandgap Temperature Coefficient (degrees)

parameter real TNFACTOR = 0.0;					// Temperature exponent for NFACTOR

parameter real UTE 	= -1.5;					// Mobility temperature exponent
parameter real LUTE 	= 0.0;
parameter real WUTE 	= 0.0;
parameter real PUTE 	= 0.0;
parameter real UTEL 	= 0.0;					// Length Scaling parameter for UTE

parameter real UA1	= 1.0e-3;				// Temperature coefficient for UA
parameter real LUA1 	= 0.0;
parameter real WUA1 	= 0.0;
parameter real PUA1 	= 0.0;
parameter real UA1L 	= 0.0;					// Length Scaling parameter for UA1

parameter real UC1	= 0.056e-9;				// Temperature coefficient for UC
parameter real LUC1 	= 0.0;
parameter real WUC1 	= 0.0;
parameter real PUC1 	= 0.0;
parameter real UD1	= 0.0;					// Temperature coefficient for UD
parameter real LUD1 	= 0.0;
parameter real WUD1 	= 0.0;
parameter real PUD1 	= 0.0;
parameter real UD1L 	= 0.0;					// Length Scaling parameter for UD1

parameter real UCSTE	= -4.775e-3;				// Temperature coefficient for UCS
parameter real LUCSTE 	= 0.0;
parameter real WUCSTE 	= 0.0;
parameter real PUCSTE 	= 0.0;

parameter real TETA0	= 0.0;					// Temperature coefficient for ETA0

parameter real PRT	= 0.0;					// Temperature coefficient for resistance
parameter real LPRT 	= 0.0;
parameter real WPRT 	= 0.0;
parameter real PPRT 	= 0.0;

parameter real AT	= -1.56e-3;				// Temperature coefficient for saturation velocity
parameter real LAT	= 0.0;
parameter real WAT	= 0.0;
parameter real PAT	= 0.0;
parameter real ATL 	= 0.0;					// Length Scaling parameter for AT

parameter real TDELTA	= 0.0;					// Temperature coefficient for DELTA

parameter real PTWGT	= 0.0;					// Temperature coefficient for PTWG
parameter real LPTWGT	= 0.0;
parameter real WPTWGT	= 0.0;
parameter real PPTWGT	= 0.0;
parameter real PTWGTL 	= 0.0;					// Length Scaling parameter for PTWGT

parameter real KT1	= -0.11;				// Temperature coefficient for Vth
parameter real KT1EXP	= 1.0 from (0:inf);			// Temperature coefficient for Vth
parameter real KT1L	= 0.0;					// Temperature coefficient for Vth
parameter real LKT1	= 0.0;
parameter real WKT1	= 0.0;
parameter real PKT1	= 0.0;

parameter real KT2	= 0.022;				// Temperature coefficient for Vth
parameter real LKT2	= 0.0;
parameter real WKT2	= 0.0;
parameter real PKT2	= 0.0;

parameter real IIT	= 0.0;					// Temperature coefficient for BETA0
parameter real LIIT	= 0.0;
parameter real WIIT	= 0.0;
parameter real PIIT	= 0.0;

parameter real IGT	= 2.5;					// Gate Current Temperature Dependence
parameter real LIGT	= 0.0;
parameter real WIGT	= 0.0;
parameter real PIGT	= 0.0;

parameter real TGIDL	= 0.0;					// Temperature coefficient for GIDL/GISL
parameter real LTGIDL	= 0.0;
parameter real WTGIDL	= 0.0;
parameter real PTGIDL	= 0.0;

parameter real TCJ 	= 0.0;					// Temperature coefficient for CJS/CJD
parameter real TCJSW 	= 0.0;					// Temperature coefficient for CJSWS/CJSWD
parameter real TCJSWG 	= 0.0;					// Temperature coefficient for CJSWGS/CJSWGD
parameter real TPB 	= 0.0;					// Temperature coefficient for PBS/PBD
parameter real TPBSW 	= 0.0;					// Temperature coefficient for PBSWS/PBSWD
parameter real TPBSWG 	= 0.0;					// Temperature coefficient for PBSWGS/PBSWGD
parameter real XTIS 	= 3.0;					// Source junction current temperature exponent
parameter real XTID 	= 3.0;					// Drain junction current temperature exponent
parameter real XTSS 	= 0.02;					// Power dependence of JTSS on temperature
parameter real XTSD 	= 0.02;					// Power dependence of JTSD on temperature
parameter real XTSSWS 	= 0.02;					// Power dependence of JTSSWS on temperature
parameter real XTSSWD 	= 0.02;					// Power dependence of JTSSWD on temperature
parameter real XTSSWGS 	= 0.02;					// Power dependence of JTSSWGS on temperature
parameter real XTSSWGD 	= 0.02;					// Power dependence of JTSSWGD on temperature
parameter real TNJTS 	= 0.0;					// Temperature coefficient for NJTS
parameter real TNJTSD 	= 0.0;					// Temperature coefficient for NJTSD
parameter real TNJTSSW 	= 0.0;					// Temperature coefficient for NJTSSW
parameter real TNJTSSWD = 0.0;					// Temperature coefficient for NJTSSWD
parameter real TNJTSSWG = 0.0;					// Temperature coefficient for NJTSSWG
parameter real TNJTSSWGD = 0.0;					// Temperature coefficient for NJTSSWGD

// BSIM model Self Heating Parameter
parameter real RTH0    = 0.0;                                   // Thermal resistance
parameter real CTH0    = 1.0E-05;                               // Thermal capacitance
parameter real WTH0    = 0.0;                                   // Width dependence coefficient for Rth and Cth

// BSIM model Stress related Parameter
parameter real SA 	= 0.0;					// Distance between OD edge from Poly from one side
parameter real SB 	= 0.0;					// Distance between OD edge from Poly from other side
parameter real SD 	= 0.0;					// Distance between neighboring fingers
parameter real SAREF 	= 1.0e-6 from (0:inf);			// Reference distance between OD edge from Poly from one side
parameter real SBREF 	= 1.0e-6 from (0:inf);			// Reference distance between OD edge from Poly from other side
parameter real WLOD 	= 0.0	 from [0:inf);			// Width Parameter for Stress Effect
parameter real KU0 	= 0.0;					// Mobility degradation/enhancement Parameter for Stress Effect
parameter real KVSAT 	= 0.0;					// Saturation Velocity degradation/enhancement Parameter for Stress Effect
parameter real TKU0 	= 0.0;					// Temperature Coefficient for KU0
parameter real LKU0 	= 0.0;					// Length Dependence of KU0
parameter real WKU0 	= 0.0;					// Width Dependence of KU0
parameter real PKU0 	= 0.0;					// Cross Term Dependence of KU0
parameter real LLODKU0 	= 0.0;					// Length Parameter for u0 stress effect
parameter real WLODKU0 	= 0.0;					// Width Parameter for u0 stress effect
parameter real KVTH0 	= 0.0;					// Threshold Shift parameter for stress effect
parameter real LKVTH0 	= 0.0;					// Length dependence of KVTH0
parameter real WKVTH0 	= 0.0;					// Width dependence of KVTH0
parameter real PKVTH0 	= 0.0;					// Cross-term dependence of KVTH0
parameter real LLODVTH 	= 0.0;					// Length Parameter for Vth stress effect
parameter real WLODVTH 	= 0.0;					// Width Parameter for Vth stress effect
parameter real STK2 	= 0.0;					// K2 shift factor related to Vth change
parameter real LODK2 	= 0.0;					// K2 shift modification factor for stress effect
parameter real STETA0 	= 0.0;					// eta0 shift related to Vth0 change
parameter real LODETA0 	= 0.0;					// eta0 modification foator for stress effect
// BSMI model Well Proximity Parameters
parameter real SCA 	= 0.0;					//Integration of first distribution function for scattered well dopant
parameter real SCB 	= 0.0;					//Integration of second distribution function for scattered well dopant
parameter real SCC 	= 0.0;					//Integration of second distribution function for scattered well dopant
parameter real SC 	= 0.0;					//Distance to a single well edge
parameter real WEB 	= 0.0;					//Coefficient for SCB
parameter real WEC 	= 0.0;					//Coefficient for SCC
parameter real KVTH0WE 	= 0.0;					//Vth shift for well proximity effect
parameter real LKVTH0WE = 0.0;
parameter real WKVTH0WE = 0.0;
parameter real PKVTH0WE = 0.0;
parameter real K2WE 	= 0.0;					//K2 shift for well proximity effect
parameter real LK2WE 	= 0.0;
parameter real WK2WE 	= 0.0;
parameter real PK2WE 	= 0.0;
parameter real KU0WE 	= 0.0;					//Mobility degradation factor for well proximity effect
parameter real LKU0WE 	= 0.0;
parameter real WKU0WE 	= 0.0;
parameter real PKU0WE 	= 0.0;
parameter real SCREF 	= 1.0e-6;				//Reference distance to calculate SCA,SCB and SCC
// BSIM model GMIN - added for convergence
//parameter real GMIN		= $simparam("gmin", 1.0e-15);

//======================================================================
// Internal nodes
//======================================================================
kinematic [0:`RBT_NMODES-1] x;

//======================================================================
// Model Instances
//======================================================================

// Driving capacitor
rbtCapTrans #(
	.rbt_g(rbt_g), .rbt_epsd(rbt_epsd), .rbt_L(rbt_L), .rbt_W(rbt_W),
	.rbt_THK(rbt_THK), .rbt_d(rbt_d), .rbt_LTC(rbt_LTC), .rbt_LDTC(rbt_LDTC),
	.rbt_Tnom(rbt_Tnom)
)  rbtCapTransInst (p,n,x,T);

// Resonant body module
rbtBody #(
	.rbt_L(rbt_L), .rbt_W(rbt_W), .rbt_THK(rbt_THK), .rbt_rho(rbt_rho), .rbt_Y(rbt_Y),
	.rbt_nu(rbt_nu), .rbt_fQ(rbt_fQ), .rbt_LTC(rbt_LTC), .rbt_rhoTC(rbt_rhoTC),
	.rbt_YTC(rbt_YTC), .rbt_nuTC(rbt_nuTC), .rbt_fQTC(rbt_fQTC), .rbt_Tnom(rbt_Tnom),
	.rbt_fQharm(rbt_fQharm)
)  rbtBodyInst (x,T);

// Thermal module
rbtThermal #(
	.rbt_L(rbt_L), .rbt_Rth(rbt_Rth), .rbt_cm(rbt_cm),
	.rbt_W(rbt_W), .rbt_THK(rbt_THK), .rbt_rho(rbt_rho)
) rbtThermalInst (T);

// Parasitics module
rbtParasitics #(
	.rbt_Cfpd(rbt_Cfpd), .rbt_Cfpg(rbt_Cfpg), .rbt_Cfps(rbt_Cfps), .rbt_Cfpb(rbt_Cfpb),
	.rbt_Rfpd(rbt_Rfpd), .rbt_Rfpg(rbt_Rfpg), .rbt_Rfps(rbt_Rfps), .rbt_Rfpb(rbt_Rfpb),
	.rbt_Rfnb(rbt_Rfnb), .rbt_Tnom(rbt_Tnom)
) rbtParasiticsInst(p,n,d,g,s,b,x,T);

// rbtBSIM6 sensing FET
rbtBSIM6 #(
	.rbt_L(rbt_L), .rbt_HSense(rbt_HSense),
	.rbt_Lso(rbt_Lso), .rbt_pitrans(rbt_pitrans), .rbt_pilong(rbt_pilong), .rbt_Y(rbt_Y), .rbt_nu(rbt_nu),
	.rbt_LTC(rbt_LTC), .rbt_LSTC(rbt_LSTC), .rbt_YTC(rbt_YTC), .rbt_nuTC(rbt_nuTC), .rbt_Tnom(rbt_Tnom),
	.TYPE(TYPE), .CVMOD(CVMOD), .GEOMOD(GEOMOD), .RGEOMOD(RGEOMOD), .COVMOD(COVMOD),
	.RDSMOD(RDSMOD), .GIDLMOD(GIDLMOD), .RGATEMOD(RGATEMOD), .RBODYMOD(RBODYMOD), .IGCMOD(IGCMOD),
	.IGBMOD(IGBMOD), .TNOIMOD(TNOIMOD), .SHMOD(SHMOD), .L(L), .LLONG(LLONG),
	.LMLT(LMLT), .WMLT(WMLT), .XL(XL), .W(W), .WWIDE(WWIDE),
	.XW(XW), .LINT(LINT), .LL(LL), .LW(LW), .LWL(LWL),
	.LLN(LLN), .LWN(LWN), .WINT(WINT), .WL(WL), .WW(WW),
	.WWL(WWL), .WLN(WLN), .WWN(WWN), .DLC(DLC), .LLC(LLC),
	.LWC(LWC), .LWLC(LWLC), .DWC(DWC), .WLC(WLC), .WWC(WWC),
	.WWLC(WWLC), .TOXE(TOXE), .TOXP(TOXP), .DTOX(DTOX), .NF(NF),
	.NDEP(NDEP), .NDEPL1(NDEPL1), .NDEPLEXP1(NDEPLEXP1), .NDEPL2(NDEPL2), .NDEPLEXP2(NDEPLEXP2),
	.NDEPW(NDEPW), .NDEPWEXP(NDEPWEXP), .NDEPWL(NDEPWL), .NDEPWLEXP(NDEPWLEXP), .LNDEP(LNDEP),
	.WNDEP(WNDEP), .PNDEP(PNDEP), .NDEPCV(NDEPCV), .NDEPCVL1(NDEPCVL1), .NDEPCVLEXP1(NDEPCVLEXP1),
	.NDEPCVL2(NDEPCVL2), .NDEPCVLEXP2(NDEPCVLEXP2), .NDEPCVW(NDEPCVW), .NDEPCVWEXP(NDEPCVWEXP), .NDEPCVWL(NDEPCVWL),
	.NDEPCVWLEXP(NDEPCVWLEXP), .LNDEPCV(LNDEPCV), .WNDEPCV(WNDEPCV), .PNDEPCV(PNDEPCV), .NGATE(NGATE),
	.LNGATE(LNGATE), .WNGATE(WNGATE), .PNGATE(PNGATE), .EASUB(EASUB), .NI0SUB(NI0SUB),
	.BG0SUB(BG0SUB), .EPSRSUB(EPSRSUB), .EPSROX(EPSROX), .XJ(XJ), .LXJ(LXJ),
	.WXJ(WXJ), .PXJ(PXJ), .VFB(VFB), .LVFB(LVFB), .WVFB(WVFB),
	.PVFB(PVFB), .VFBCV(VFBCV), .LVFBCV(LVFBCV), .WVFBCV(WVFBCV), .PVFBCV(PVFBCV),
	.VFBCVL(VFBCVL), .VFBCVLEXP(VFBCVLEXP), .VFBCVW(VFBCVW), .VFBCVWEXP(VFBCVWEXP), .VFBCVWL(VFBCVWL),
	.VFBCVWLEXP(VFBCVWLEXP), .PERMOD(PERMOD), .AS(AS), .AD(AD), .PS(PS),
	.PD(PD), .DWJ(DWJ), .VFBSDOFF(VFBSDOFF), .NRS(NRS), .NRD(NRD),
	.MINZ(MINZ), .NSD(NSD), .LNSD(LNSD), .WNSD(WNSD), .PNSD(PNSD),
	.DVTP0(DVTP0), .LDVTP0(LDVTP0), .WDVTP0(WDVTP0), .PDVTP0(PDVTP0), .DVTP1(DVTP1),
	.LDVTP1(LDVTP1), .WDVTP1(WDVTP1), .PDVTP1(PDVTP1), .DVTP2(DVTP2), .LDVTP2(LDVTP2),
	.WDVTP2(WDVTP2), .PDVTP2(PDVTP2), .DVTP3(DVTP3), .LDVTP3(LDVTP3), .WDVTP3(WDVTP3),
	.PDVTP3(PDVTP3), .DVTP4(DVTP4), .LDVTP4(LDVTP4), .WDVTP4(WDVTP4), .PDVTP4(PDVTP4),
	.DVTP5(DVTP5), .LDVTP5(LDVTP5), .WDVTP5(WDVTP5), .PDVTP5(PDVTP5), .PHIN(PHIN),
	.LPHIN(LPHIN), .WPHIN(WPHIN), .PPHIN(PPHIN), .ETA0(ETA0), .LETA0(LETA0),
	.WETA0(WETA0), .PETA0(PETA0), .DSUB(DSUB), .ETAB(ETAB), .ETABEXP(ETABEXP),
	.LETAB(LETAB), .WETAB(WETAB), .PETAB(PETAB), .K2(K2), .K2L(K2L),
	.K2LEXP(K2LEXP), .K2W(K2W), .K2WEXP(K2WEXP), .K2WL(K2WL), .K2WLEXP(K2WLEXP),
	.LK2(LK2), .WK2(WK2), .PK2(PK2), .ADOS(ADOS), .BDOS(BDOS),
	.QM0(QM0), .ETAQM(ETAQM), .CIT(CIT), .LCIT(LCIT), .WCIT(WCIT),
	.PCIT(PCIT), .NFACTOR(NFACTOR), .NFACTORL(NFACTORL), .NFACTORLEXP(NFACTORLEXP), .NFACTORW(NFACTORW),
	.NFACTORWEXP(NFACTORWEXP), .NFACTORWL(NFACTORWL), .NFACTORWLEXP(NFACTORWLEXP), .LNFACTOR(LNFACTOR), .WNFACTOR(WNFACTOR),
	.PNFACTOR(PNFACTOR), .CDSCD(CDSCD), .CDSCDL(CDSCDL), .CDSCDLEXP(CDSCDLEXP), .LCDSCD(LCDSCD),
	.WCDSCD(WCDSCD), .PCDSCD(PCDSCD), .CDSCB(CDSCB), .CDSCBL(CDSCBL), .CDSCBLEXP(CDSCBLEXP),
	.LCDSCB(LCDSCB), .WCDSCB(WCDSCB), .PCDSCB(PCDSCB), .VSAT(VSAT), .LVSAT(LVSAT),
	.WVSAT(WVSAT), .PVSAT(PVSAT), .VSATL(VSATL), .VSATLEXP(VSATLEXP), .VSATW(VSATW),
	.VSATWEXP(VSATWEXP), .VSATWL(VSATWL), .VSATWLEXP(VSATWLEXP), .DELTA(DELTA), .LDELTA(LDELTA),
	.WDELTA(WDELTA), .PDELTA(PDELTA), .DELTAL(DELTAL), .DELTALEXP(DELTALEXP), .VSATCV(VSATCV),
	.LVSATCV(LVSATCV), .WVSATCV(WVSATCV), .PVSATCV(PVSATCV), .VSATCVL(VSATCVL), .VSATCVLEXP(VSATCVLEXP),
	.VSATCVW(VSATCVW), .VSATCVWEXP(VSATCVWEXP), .VSATCVWL(VSATCVWL), .VSATCVWLEXP(VSATCVWLEXP), .U0(U0),
	.U0L(U0L), .U0LEXP(U0LEXP), .LU0(LU0), .WU0(WU0), .PU0(PU0),
	.ETAMOB(ETAMOB), .UA(UA), .UAL(UAL), .UALEXP(UALEXP), .UAW(UAW),
	.UAWEXP(UAWEXP), .UAWL(UAWL), .UAWLEXP(UAWLEXP), .LUA(LUA), .WUA(WUA),
	.PUA(PUA), .EU(EU), .LEU(LEU), .WEU(WEU), .PEU(PEU),
	.EUL(EUL), .EULEXP(EULEXP), .EUW(EUW), .EUWEXP(EUWEXP), .EUWL(EUWL),
	.EUWLEXP(EUWLEXP), .UD(UD), .UDL(UDL), .UDLEXP(UDLEXP), .LUD(LUD),
	.WUD(WUD), .PUD(PUD), .UCS(UCS), .LUCS(LUCS), .WUCS(WUCS),
	.PUCS(PUCS), .UC(UC), .UCL(UCL), .UCLEXP(UCLEXP), .UCW(UCW),
	.UCWEXP(UCWEXP), .UCWL(UCWL), .UCWLEXP(UCWLEXP), .LUC(LUC), .WUC(WUC),
	.PUC(PUC), .PCLM(PCLM), .PCLML(PCLML), .PCLMLEXP(PCLMLEXP), .LPCLM(LPCLM),
	.WPCLM(WPCLM), .PPCLM(PPCLM), .PCLMG(PCLMG), .PCLMCV(PCLMCV), .PCLMCVL(PCLMCVL),
	.PCLMCVLEXP(PCLMCVLEXP), .LPCLMCV(LPCLMCV), .WPCLMCV(WPCLMCV), .PPCLMCV(PPCLMCV), .PSCBE1(PSCBE1),
	.LPSCBE1(LPSCBE1), .WPSCBE1(WPSCBE1), .PPSCBE1(PPSCBE1), .PSCBE2(PSCBE2), .LPSCBE2(LPSCBE2),
	.WPSCBE2(WPSCBE2), .PPSCBE2(PPSCBE2), .PDITS(PDITS), .LPDITS(LPDITS), .WPDITS(WPDITS),
	.PPDITS(PPDITS), .PDITSL(PDITSL), .PDITSD(PDITSD), .LPDITSD(LPDITSD), .WPDITSD(WPDITSD),
	.PPDITSD(PPDITSD), .RSH(RSH), .PRWG(PRWG), .LPRWG(LPRWG), .WPRWG(WPRWG),
	.PPRWG(PPRWG), .PRWB(PRWB), .LPRWB(LPRWB), .WPRWB(WPRWB), .PPRWB(PPRWB),
	.PRWBL(PRWBL), .PRWBLEXP(PRWBLEXP), .WR(WR), .LWR(LWR), .WWR(WWR),
	.PWR(PWR), .RSWMIN(RSWMIN), .LRSWMIN(LRSWMIN), .WRSWMIN(WRSWMIN), .PRSWMIN(PRSWMIN),
	.RSW(RSW), .LRSW(LRSW), .WRSW(WRSW), .PRSW(PRSW), .RSWL(RSWL),
	.RSWLEXP(RSWLEXP), .RDWMIN(RDWMIN), .LRDWMIN(LRDWMIN), .WRDWMIN(WRDWMIN), .PRDWMIN(PRDWMIN),
	.RDW(RDW), .LRDW(LRDW), .WRDW(WRDW), .PRDW(PRDW), .RDWL(RDWL),
	.RDWLEXP(RDWLEXP), .RDSWMIN(RDSWMIN), .LRDSWMIN(LRDSWMIN), .WRDSWMIN(WRDSWMIN), .PRDSWMIN(PRDSWMIN),
	.RDSW(RDSW), .RDSWL(RDSWL), .RDSWLEXP(RDSWLEXP), .LRDSW(LRDSW), .WRDSW(WRDSW),
	.PRDSW(PRDSW), .PSAT(PSAT), .LPSAT(LPSAT), .WPSAT(WPSAT), .PPSAT(PPSAT),
	.PSATL(PSATL), .PSATLEXP(PSATLEXP), .PSATB(PSATB), .LPSATB(LPSATB), .WPSATB(WPSATB),
	.PPSATB(PPSATB), .PSATX(PSATX), .PTWG(PTWG), .LPTWG(LPTWG), .WPTWG(WPTWG),
	.PPTWG(PPTWG), .PTWGL(PTWGL), .PTWGLEXP(PTWGLEXP), .PDIBLC(PDIBLC), .PDIBLCL(PDIBLCL),
	.PDIBLCLEXP(PDIBLCLEXP), .LPDIBLC(LPDIBLC), .WPDIBLC(WPDIBLC), .PPDIBLC(PPDIBLC), .PDIBLCB(PDIBLCB),
	.LPDIBLCB(LPDIBLCB), .WPDIBLCB(WPDIBLCB), .PPDIBLCB(PPDIBLCB), .PVAG(PVAG), .LPVAG(LPVAG),
	.WPVAG(WPVAG), .PPVAG(PPVAG), .FPROUT(FPROUT), .FPROUTL(FPROUTL), .FPROUTLEXP(FPROUTLEXP),
	.LFPROUT(LFPROUT), .WFPROUT(WFPROUT), .PFPROUT(PFPROUT), .ALPHA0(ALPHA0), .ALPHA0L(ALPHA0L),
	.ALPHA0LEXP(ALPHA0LEXP), .LALPHA0(LALPHA0), .WALPHA0(WALPHA0), .PALPHA0(PALPHA0), .BETA0(BETA0),
	.LBETA0(LBETA0), .WBETA0(WBETA0), .PBETA0(PBETA0), .AIGBACC(AIGBACC), .BIGBACC(BIGBACC),
	.CIGBACC(CIGBACC), .NIGBACC(NIGBACC), .AIGBINV(AIGBINV), .BIGBINV(BIGBINV), .CIGBINV(CIGBINV),
	.EIGBINV(EIGBINV), .NIGBINV(NIGBINV), .AIGC(AIGC), .BIGC(BIGC), .CIGC(CIGC),
	.AIGS(AIGS), .BIGS(BIGS), .CIGS(CIGS), .AIGD(AIGD), .BIGD(BIGD),
	.CIGD(CIGD), .DLCIG(DLCIG), .DLCIGD(DLCIGD), .POXEDGE(POXEDGE), .NTOX(NTOX),
	.TOXREF(TOXREF), .PIGCD(PIGCD), .AIGCL(AIGCL), .AIGCW(AIGCW), .AIGSL(AIGSL),
	.AIGSW(AIGSW), .AIGDL(AIGDL), .AIGDW(AIGDW), .PIGCDL(PIGCDL), .LAIGBINV(LAIGBINV),
	.WAIGBINV(WAIGBINV), .PAIGBINV(PAIGBINV), .LBIGBINV(LBIGBINV), .WBIGBINV(WBIGBINV), .PBIGBINV(PBIGBINV),
	.LCIGBINV(LCIGBINV), .WCIGBINV(WCIGBINV), .PCIGBINV(PCIGBINV), .LEIGBINV(LEIGBINV), .WEIGBINV(WEIGBINV),
	.PEIGBINV(PEIGBINV), .LNIGBINV(LNIGBINV), .WNIGBINV(WNIGBINV), .PNIGBINV(PNIGBINV), .LAIGBACC(LAIGBACC),
	.WAIGBACC(WAIGBACC), .PAIGBACC(PAIGBACC), .LBIGBACC(LBIGBACC), .WBIGBACC(WBIGBACC), .PBIGBACC(PBIGBACC),
	.LCIGBACC(LCIGBACC), .WCIGBACC(WCIGBACC), .PCIGBACC(PCIGBACC), .LNIGBACC(LNIGBACC), .WNIGBACC(WNIGBACC),
	.PNIGBACC(PNIGBACC), .LAIGC(LAIGC), .WAIGC(WAIGC), .PAIGC(PAIGC), .LBIGC(LBIGC),
	.WBIGC(WBIGC), .PBIGC(PBIGC), .LCIGC(LCIGC), .WCIGC(WCIGC), .PCIGC(PCIGC),
	.LAIGS(LAIGS), .WAIGS(WAIGS), .PAIGS(PAIGS), .LBIGS(LBIGS), .WBIGS(WBIGS),
	.PBIGS(PBIGS), .LCIGS(LCIGS), .WCIGS(WCIGS), .PCIGS(PCIGS), .LAIGD(LAIGD),
	.WAIGD(WAIGD), .PAIGD(PAIGD), .LBIGD(LBIGD), .WBIGD(WBIGD), .PBIGD(PBIGD),
	.LCIGD(LCIGD), .WCIGD(WCIGD), .PCIGD(PCIGD), .LPOXEDGE(LPOXEDGE), .WPOXEDGE(WPOXEDGE),
	.PPOXEDGE(PPOXEDGE), .LDLCIG(LDLCIG), .WDLCIG(WDLCIG), .PDLCIG(PDLCIG), .LDLCIGD(LDLCIGD),
	.WDLCIGD(WDLCIGD), .PDLCIGD(PDLCIGD), .LNTOX(LNTOX), .WNTOX(WNTOX), .PNTOX(PNTOX),
	.AGIDL(AGIDL), .AGIDLL(AGIDLL), .AGIDLW(AGIDLW), .LAGIDL(LAGIDL), .WAGIDL(WAGIDL),
	.PAGIDL(PAGIDL), .BGIDL(BGIDL), .LBGIDL(LBGIDL), .WBGIDL(WBGIDL), .PBGIDL(PBGIDL),
	.CGIDL(CGIDL), .LCGIDL(LCGIDL), .WCGIDL(WCGIDL), .PCGIDL(PCGIDL), .EGIDL(EGIDL),
	.LEGIDL(LEGIDL), .WEGIDL(WEGIDL), .PEGIDL(PEGIDL), .AGISL(AGISL), .AGISLL(AGISLL),
	.AGISLW(AGISLW), .LAGISL(LAGISL), .WAGISL(WAGISL), .PAGISL(PAGISL), .BGISL(BGISL),
	.LBGISL(LBGISL), .WBGISL(WBGISL), .PBGISL(PBGISL), .CGISL(CGISL), .LCGISL(LCGISL),
	.WCGISL(WCGISL), .PCGISL(PCGISL), .EGISL(EGISL), .LEGISL(LEGISL), .WEGISL(WEGISL),
	.PEGISL(PEGISL), .CF(CF), .LCF(LCF), .WCF(WCF), .PCF(PCF),
	.CFRCOEFF(CFRCOEFF), .CGSO(CGSO), .CGDO(CGDO), .CGBO(CGBO), .CGSL(CGSL),
	.LCGSL(LCGSL), .WCGSL(WCGSL), .PCGSL(PCGSL), .CGDL(CGDL), .LCGDL(LCGDL),
	.WCGDL(WCGDL), .PCGDL(PCGDL), .CKAPPAS(CKAPPAS), .LCKAPPAS(LCKAPPAS), .WCKAPPAS(WCKAPPAS),
	.PCKAPPAS(PCKAPPAS), .CKAPPAD(CKAPPAD), .LCKAPPAD(LCKAPPAD), .WCKAPPAD(WCKAPPAD), .PCKAPPAD(PCKAPPAD),
	.DMCG(DMCG), .DMCI(DMCI), .DMDG(DMDG), .DMCGT(DMCGT),
	`ifdef __RGATEMOD__
	.XGW(XGW), .XGL(XGL), .NGCON(NGCON), .RSHG(RSHG),
	`endif
	.CJS(CJS), .CJD(CJD), .CJSWS(CJSWS), .CJSWD(CJSWD), .CJSWGS(CJSWGS),
	.CJSWGD(CJSWGD), .PBS(PBS), .PBD(PBD), .PBSWS(PBSWS), .PBSWD(PBSWD),
	.PBSWGS(PBSWGS), .PBSWGD(PBSWGD), .MJS(MJS), .MJD(MJD), .MJSWS(MJSWS),
	.MJSWD(MJSWD), .MJSWGS(MJSWGS), .MJSWGD(MJSWGD), .JSS(JSS), .JSD(JSD),
	.JSWS(JSWS), .JSWD(JSWD), .JSWGS(JSWGS), .JSWGD(JSWGD), .NJS(NJS),
	.NJD(NJD), .IJTHSFWD(IJTHSFWD), .IJTHDFWD(IJTHDFWD), .IJTHSREV(IJTHSREV), .IJTHDREV(IJTHDREV),
	.BVS(BVS), .BVD(BVD), .XJBVS(XJBVS), .XJBVD(XJBVD), .JTSS(JTSS),
	.JTSD(JTSD), .JTSSWS(JTSSWS), .JTSSWD(JTSSWD), .JTSSWGS(JTSSWGS), .JTSSWGD(JTSSWGD),
	.JTWEFF(JTWEFF), .NJTS(NJTS), .NJTSD(NJTSD), .NJTSSW(NJTSSW), .NJTSSWD(NJTSSWD),
	.NJTSSWG(NJTSSWG), .NJTSSWGD(NJTSSWGD), .VTSS(VTSS), .VTSD(VTSD), .VTSSWS(VTSSWS),
	.VTSSWD(VTSSWD), .VTSSWGS(VTSSWGS), .VTSSWGD(VTSSWGD),
	`ifdef __RGATEMOD__
	.XRCRG1(XRCRG1), .XRCRG2(XRCRG2),
	`endif
	`ifdef __RBODYMOD__
	.RBPB(RBPB), .RBDB(RBDB),
	.RBSB(RBSB), .RBPS(RBPS), .RBPD(RBPD), .GBMIN(GBMIN), .RBPS0(RBPS0),
	.RBPSL(RBPSL), .RBPSW(RBPSW), .RBPSNF(RBPSNF), .RBPD0(RBPD0), .RBPDL(RBPDL),
	.RBPDW(RBPDW), .RBPDNF(RBPDNF), .RBPBX0(RBPBX0), .RBPBXL(RBPBXL), .RBPBXW(RBPBXW),
	.RBPBXNF(RBPBXNF), .RBPBY0(RBPBY0), .RBPBYL(RBPBYL), .RBPBYW(RBPBYW), .RBPBYNF(RBPBYNF),
	.RBSBX0(RBSBX0), .RBSBY0(RBSBY0), .RBDBX0(RBDBX0), .RBDBY0(RBDBY0), .RBSDBXL(RBSDBXL),
	.RBSDBXW(RBSDBXW), .RBSDBXNF(RBSDBXNF), .RBSDBYL(RBSDBYL), .RBSDBYW(RBSDBYW), .RBSDBYNF(RBSDBYNF),
	`endif
	.EF(EF), .EM(EM), .NOIA(NOIA), .NOIB(NOIB), .NOIC(NOIC), .LINTNOI(LINTNOI), .NTNOI(NTNOI),
	`ifdef __TNOISW__
	.RNOIA(RNOIA), .RNOIB(RNOIB), .RNOIC(RNOIC), .TNOIA(TNOIA), .TNOIB(TNOIB), .TNOIC(TNOIC),
	`endif
	.BINUNIT(BINUNIT), .DLBIN(DLBIN), .DWBIN(DWBIN), .TNOM(TNOM),
	.DTEMP(DTEMP), .TBGASUB(TBGASUB), .TBGBSUB(TBGBSUB), .TNFACTOR(TNFACTOR), .UTE(UTE),
	.LUTE(LUTE), .WUTE(WUTE), .PUTE(PUTE), .UTEL(UTEL), .UA1(UA1),
	.LUA1(LUA1), .WUA1(WUA1), .PUA1(PUA1), .UA1L(UA1L), .UC1(UC1),
	.LUC1(LUC1), .WUC1(WUC1), .PUC1(PUC1), .UD1(UD1), .LUD1(LUD1),
	.WUD1(WUD1), .PUD1(PUD1), .UD1L(UD1L), .UCSTE(UCSTE), .LUCSTE(LUCSTE),
	.WUCSTE(WUCSTE), .PUCSTE(PUCSTE), .TETA0(TETA0), .PRT(PRT), .LPRT(LPRT),
	.WPRT(WPRT), .PPRT(PPRT), .AT(AT), .LAT(LAT), .WAT(WAT),
	.PAT(PAT), .ATL(ATL), .TDELTA(TDELTA), .PTWGT(PTWGT), .LPTWGT(LPTWGT),
	.WPTWGT(WPTWGT), .PPTWGT(PPTWGT), .PTWGTL(PTWGTL), .KT1(KT1), .KT1EXP(KT1EXP),
	.KT1L(KT1L), .LKT1(LKT1), .WKT1(WKT1), .PKT1(PKT1), .KT2(KT2),
	.LKT2(LKT2), .WKT2(WKT2), .PKT2(PKT2), .IIT(IIT), .LIIT(LIIT),
	.WIIT(WIIT), .PIIT(PIIT), .IGT(IGT), .LIGT(LIGT), .WIGT(WIGT),
	.PIGT(PIGT), .TGIDL(TGIDL), .LTGIDL(LTGIDL), .WTGIDL(WTGIDL), .PTGIDL(PTGIDL),
	.TCJ(TCJ), .TCJSW(TCJSW), .TCJSWG(TCJSWG), .TPB(TPB), .TPBSW(TPBSW),
	.TPBSWG(TPBSWG), .XTIS(XTIS), .XTID(XTID), .XTSS(XTSS), .XTSD(XTSD),
	.XTSSWS(XTSSWS), .XTSSWD(XTSSWD), .XTSSWGS(XTSSWGS), .XTSSWGD(XTSSWGD), .TNJTS(TNJTS),
	.TNJTSD(TNJTSD), .TNJTSSW(TNJTSSW), .TNJTSSWD(TNJTSSWD), .TNJTSSWG(TNJTSSWG), .TNJTSSWGD(TNJTSSWGD),
	.RTH0(RTH0), .CTH0(CTH0), .WTH0(WTH0), .SA(SA), .SB(SB),
	.SD(SD), .SAREF(SAREF), .SBREF(SBREF), .WLOD(WLOD), .KU0(KU0),
	.KVSAT(KVSAT), .TKU0(TKU0), .LKU0(LKU0), .WKU0(WKU0), .PKU0(PKU0),
	.LLODKU0(LLODKU0), .WLODKU0(WLODKU0), .KVTH0(KVTH0), .LKVTH0(LKVTH0), .WKVTH0(WKVTH0),
	.PKVTH0(PKVTH0), .LLODVTH(LLODVTH), .WLODVTH(WLODVTH), .STK2(STK2), .LODK2(LODK2),
	.STETA0(STETA0), .LODETA0(LODETA0), .SCA(SCA), .SCB(SCB), .SCC(SCC),
	.SC(SC), .WEB(WEB), .WEC(WEC), .KVTH0WE(KVTH0WE), .LKVTH0WE(LKVTH0WE),
	.WKVTH0WE(WKVTH0WE), .PKVTH0WE(PKVTH0WE), .K2WE(K2WE), .LK2WE(LK2WE), .WK2WE(WK2WE),
	.PK2WE(PK2WE), .KU0WE(KU0WE), .LKU0WE(LKU0WE), .WKU0WE(WKU0WE), .PKU0WE(PKU0WE),
	.SCREF(SCREF)
	// .GMIN(GMIN)
) rbtBSIM6Inst (d,g,s,b, x,T);

endmodule
