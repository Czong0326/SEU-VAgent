//  VerilogA baseband behavioral model of a downconverting mixer.
//  Copyright (c) 2000
//  by Cadence Design Systems, Inc.  All rights reserved.

// 1/6/00

/*
This is a simple passband model of a mixer. The local
oscillator is absorbed into this model.
*/

/* PARAMETER DEFINITIONS:
======================
gain    = Available power gain in dB.
IP3     = input referenced IP3(dBm)
psinf   = output phase shift as the input power goes to infinity.
nf      = noise figure [dB]
rin     = input resistance
rout    = output resistance
flo     = Local oscillator frequency
=====================
*/

`define PI 3.1415926535897932384626433

`include "constants.h"
`include "discipline.h"

module MIXER_PB(in ,out, phase_err);
inout in ;
electrical in ;
inout out;
electrical out;
inout phase_err;
electrical phase_err;

parameter real gain = 40;
parameter real ip3 = -30;
parameter real rin = 50 from (0:inf);
parameter real rout = 50 from (0:inf);

parameter real nf = 2 from [0:inf];

parameter real flo = 0.9e9;

real a;
real b;
real ip;
real rho;
real rhooutmax;
real rhoinmax;
real rhoout;
real theta;
real tmp;
real noise_current;
real rnf;

analog begin

// The initial block converts the input parameters from engineering
// units to implementation units.
   @( initial_step) begin
     a = sqrt(pow(10,gain/10)*rout/rin);
     ip = sqrt(pow(10,ip3/10)*2*rin*0.001);
     rnf = pow(10,nf/10);
     b = a/(ip*ip)*4/3;
     rhoinmax = sqrt(a/(3*b));
     rhooutmax = (2*a/3)*rhoinmax;
     noise_current = sqrt(4*(rnf-1)*1.380620e-23*$temperature/rin);

//   Use the sign of the difference between RF and LO frequencies
//   to determine whether the IF baseband equivalent rotates  CC or CCW.

   end

  rho = V(in);

// Apply the third order non-linearity. Clamp the
// output for extreme inputs.
  if (abs(rho) < rhoinmax ) rhoout = (a - b*rho*rho)*rho;
  else if (rho >0) rhoout = rhooutmax;
  else  rhoout = -rhooutmax;

  theta = flo*($abstime);

  I(phase_err) <+ V(phase_err)/50;
  I(in) <+ V(in)/rin;
  I(out) <+ (-4*rhoout*cos(2*`PI*theta + V(phase_err)) + V(out))/rout;

  I(in) <+ white_noise(noise_current*noise_current, "MIXER_PB");

end

endmodule
