//======================================================================
//Copyright @ 2016 Massachusetts Institute of Technology (MIT)
//
// The terms under which the software and associated documentation
// (the Software) is provided are as the following:
//
// The Software is provided "as is", without warranty of any kind,
// express or implied, including but not limited to the warranties of
// merchantability, fitness for a particular purpose and noninfringement.
// In no event shall the authors or copyright holders be liable for any claim,
// damages or other liability, whether in an action of contract,
// tort or otherwise, arising from, out of or in connection with the Software
// or the use or other dealings in the Software.
//
// MIT grants, free of charge, to any users the right to modify, copy,
// and redistribute the Software, both within the user's organization and
// externally, subject to the following restrictions:
//
// 1. The users agree not to charge for the MIT code itself but may charge
//      for additions, extensions, or support.
//
// 2. In any product based on the Software, the users agree to acknowledge
//      the MIT Computational Prototyping Research Group that developed
//      the software. This acknowledgment shall appear in the product
//      documentation.
//
// 3. The users agree to obey all U.S. Government restrictions governing
//      redistribution or export of the software.
//
// 4. The users agree to reproduce any copyright notice which appears on
//      the software on any copy or modification of such made available to others.
//
// Agreed to by
// Luca Daniel, MIT
// March 1st, 2016
//======================================================================
// rbtThermal.va
//======================================================================
// Thermal module for the RBT-MVS compact model
//
// Version: 1.0.0
// Tested on: Cadence Spectre 15.1.0.284.isr1
//
// Author: Bichoy Bahr [bichoy at mit dot edu]
// Last Modified: March 31st, 2016

`ifdef __RBT_THERMAL_VA__
`else
`define __RBT_THERMAL_VA__

`include "constants.vams"
`include "disciplines.vams"
`include "rbtConst.va"

module rbtThermal(T);

inout T;
thermal T;

parameter real version = 1.00;
parameter real rbt_Rth = `RBT_RTH from (0:inf);	// Thermal resistance
parameter real rbt_cm  = `RBT_CM  from (0:inf);	// Mass heat capacity
parameter real rbt_W   = `RBT_W   from (0:inf);	// Width of bar
parameter real rbt_L   = `RBT_L   from (0:inf);	// Resonator Length
parameter real rbt_THK = `RBT_THK from (0:inf);	// Thickness of the bar
parameter real rbt_rho = `RBT_RHO from (0:inf); // Density

// Thermal capacitance
localparam Cth = rbt_cm * rbt_rho * rbt_W * rbt_L * rbt_THK;

analog begin

Pwr(T) <+ Temp(T) / rbt_Rth;
Pwr(T) <+ ddt( Cth * Temp(T) );

end

endmodule

`endif
