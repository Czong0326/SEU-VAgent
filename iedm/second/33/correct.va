////////////////////////////////////////////////////////////////////////////////////////////////////////////////////////////////////////////////////////////////////////////////////////////////////////////
//Copyright @ 2014 Purdue University

//The terms under which the software and associated documentation (the Software) is provided are as the following:

//The Software is provided "as is", without warranty of any kind, express or implied, including but not limited to the warranties of merchantability,
// fitness for a particular purpose and noninfringement. In no event shall the authors or copyright holders be liable for any claim, damages or other
// liability, whether in an action of contract, tort or otherwise, arising from, out of or in connection with the Software or the use or other dealings
// in the Software.

//Purdue grants, free of charge, to any users the right to modify, copy, and redistribute the Software, both within the user's organization and externally, subject to the following restrictions:

//1. The users agree not to charge for the code itself but may charge for additions, extensions, or support.

//2. In any product based on the Software, the users agree to acknowledge the Biosensor model Research Group that developed the software. This
// acknowledgment shall appear in the product documentation.

//3. The users agree to obey all U.S. Government restrictions governing redistribution or export of the software.

//4. The users agree to reproduce any copyright notice which appears on the software on any copy or modification of such made available to others.

//Agreed to by
//Piyush Dak and Muhammad Ashraf Alam, Purdue University
//July 1, 2014
////////////////////////////////////////////////////////////////////////////////////////////////////////////////////////////////////////////////////////////////////////////////////////////////////////////

// Verilog-A version of Surface Potential Model for FET based pH sensor that accurately describes the physics of electrolyte and surface charges
// that respond to pH.
// Implemented on April 1, 2013 by Piyush Dak
// Default parameters are from Reference

`include "constants.vams"
`include "disciplines.vams"

//define relative permittivity of water
`define RP_EPSw 80
//conversion constant from moles/liter to #/m^3
`define N_AVG 6e26

module pH_robust_model_1_0_1(fgate,interface,pHnode);

 input pHnode;
 output fgate,interface;                // fgate is connected to the reference electrode, interface is in contact with the surface
 electrical fgate,interface,pHnode;

//Convention for Ka, Kb: Ka=[A-OH][Hs+]/([AOH2+], Kb=[AO-][Hs+]/[AOH]
//NOH_SI denotes the charge density of the surface groups: NOH_SI=[AOH]+[AO-]+[AOH2+]
// pH=-log10[H+], pKa=-log10[Ka], pKb=-log10[Kb]

//Parameters characterizing electrolyte and electrolyte-oxide interface
parameter real version          =   1.00;                                // pHsensor surface potential model version = 1.0.1
parameter real sternmod         =   1       from [0:1];                  // Parameter to turn on/off the stern model. 0 means that the model is off.
parameter real pKa              =   -2.0    from (-inf:inf);             // pKa of the acidic [A-OH2+] surface group
parameter real pKb              =   6.0     from (-inf:inf);             // pKb of the basic [A-OH] surface group
parameter real i0               =   0.1     from [0.0:inf];              // ionic concentration in moles/liter
parameter real Cstern           =   0.2     from (0.0:inf];              // Stern capacitance in F/m^2
parameter real NOH              =   5e14    from (0.0:inf);              // Number density of surface OH groups in cm^-2

real pH;
real ew;
real n0;
real pzc, deltapK;
real NOH_SI;
real c, deltapH;

//parameters to be used for calculation
real Q0dl, Q0, Qratio, dpH;
real vfi, tanhvfi, norm_QOH;

analog begin
        pzc           =        (pKa+pKb)/2.0;
//pHpzc is the point of zero charge i.e. pH at which the surface charge is zero assuming that surface potential is zero
        deltapK       =        pKb-pKa;
        pH            =        V(pHnode);
        deltapH       =        pH-pzc;
        c             =        limexp(`M_LN10*deltapK/2.0);
        Q0            =        2*`P_Q*NOH_SI;
        dpH           =        `M_LN10*deltapH;
        NOH_SI        =        NOH * 1e4;                                // conversion from cm^-2 to m^-2
        n0            =        `N_AVG*i0;                                      // conversion to #/m^3  (ionic concentration)
        ew            =        `RP_EPSw*`P_EPS0;                                  // permittivity of the electrolyte, in units of F/m
        Q0dl          =        sqrt(8.0 * ew * $vt * `P_Q * n0);        // prefactor for the double layer charge (in units of columb/cm^2)
        Qratio        =        Q0/Q0dl;
        vfi           =        V(interface,fgate);
        tanhvfi       =        tanh(vfi/$vt+dpH);
        norm_QOH      =        tanhvfi/ (2.0+c*sqrt(1.0-tanhvfi*tanhvfi));

    if(sternmod == 0) begin
             V(interface,fgate) <+ 2*$vt*asinh(-Qratio*norm_QOH);       // Refer Section 3.2.1 of the manual
         end
    else begin
             V(interface,fgate) <+ 2*$vt*asinh(-Qratio*norm_QOH)-Q0/Cstern*norm_QOH;    // Refer Section 3.2.2 of the manual
         end
    end

endmodule
